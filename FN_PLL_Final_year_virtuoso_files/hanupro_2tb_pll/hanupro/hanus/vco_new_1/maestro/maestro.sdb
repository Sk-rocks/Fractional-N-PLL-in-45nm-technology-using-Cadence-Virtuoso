ADE simulation setup
Run mode: Single Run, Sweeps and Corners
Tests:
  hanus_vco_new_1: hanus/vco_new/schematic, simulator spectre
    Variables: vc = {Inclusion List}0{Inclusion List}{From/To}Auto:0:20:1{From/To}; vdd = 1.2
