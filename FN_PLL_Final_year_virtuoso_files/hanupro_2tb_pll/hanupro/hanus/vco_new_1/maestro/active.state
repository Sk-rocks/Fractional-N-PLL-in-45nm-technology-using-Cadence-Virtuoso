ADE simulation setup
Test hanus_vco_new_1: hanus/vco_new/schematic, simulator spectre
  Models: /home/install/FOUNDRY/analog/45nm/gpdk045/../models/spectre/gpdk045.scs[mc]
  Variables: vc = 0; vdd = 1.2
  Temperature: 27
  Initial conditions: /vout5- = 0; /vout5+ = 1.2
  Analysis tran: stop=200n errpreset=conservative
  Output freq = frequency(VT("/vout5+"))
  Output p(50. /vout5+); pss dBmP = dbm(pvr('pss "/vout5+" 0 50.0)) (unticked)
  Output p(50. /vout5+); pss dBmP; 1 = dbm(harmonic(pvr('pss "/vout5+" 0 50.0) 1)) (unticked)
  Output harm=1 freq; pss (Hz) = harmonic(xval(getData("vout5+" ?result "pss_fd")) '1) (unticked)
  Output output noise: (PM, DSB, dBc/Hz) = rfOutputNoise("dBc/Hz" ?result "pnoise_pm" ?noiseConvention "DSB") (unticked)
  Output output noise; 1M;(PM, DSB, dBc/Hz) = drplRFValueAt(rfOutputNoise("dBc/Hz" ?result "pnoise_pm" ?noiseConvention "DSB") "1M") (unticked)
  Output Phase Noise; dBc/Hz, Relative Harmonic = 1 = pn('pnoise) (unticked)
  Output (CorFreq:PN-3dB) = "4.851e+05:-6.80e+01" (unticked)
  Signals: /vout5+
Run mode: Single Run, Sweeps and Corners
Setup values for test hanus_vco_new_1: vc = {Inclusion List}0{Inclusion List}{From/To}Auto:0:20:1{From/To}
