ADE simulation setup
Run mode: Single Run, Sweeps and Corners
Tests:
  hanus_new_vco_1: hanus/new_vco/schematic, simulator spectre
