ADE simulation setup
Test hanus_new_vco_1: hanus/new_vco/schematic, simulator spectre
  Models: /home/install/FOUNDRY/analog/45nm/gpdk045/../models/spectre/gpdk045.scs[mc]
  Temperature: 27
  Initial conditions: /net2 = 0; /net6 = 0
  Analysis pss: engine=Shooting fund=5.7G harms=30 tstab=10n oscana=t p=/net2 n=/gnd! errpreset=conservative
  Analysis pnoise: start=1 stop=25M fund=5.7G p=/net2 n=/gnd! sweeptype=relative relharmnum=1 noisetype=timeaverage
  Output Phase Noise; dBc/Hz, Relative Harmonic = 1 = pn('pnoise)
  Output (CorFreq:PN-3dB) = "2.776e+06:-7.28e+01"
  Output output noise: (PM, DSB, dBc/Hz) = rfOutputNoise("dBc/Hz" ?result "pnoise_pm" ?noiseConvention "DSB")
  Output output noise; 1M;(PM, DSB, dBc/Hz) = drplRFValueAt(rfOutputNoise("dBc/Hz" ?result "pnoise_pm" ?noiseConvention "DSB") "1M")
  Output v /net2; tran (V) = vtime('tran "/net2") (unticked)
Run mode: Single Run, Sweeps and Corners
