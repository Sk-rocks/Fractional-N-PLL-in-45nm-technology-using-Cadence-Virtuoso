ADE simulation setup
Test hanus_diffpluscapvco_1: hanus/diffpluscapvco/schematic, simulator spectre
  Models: /home/install/FOUNDRY/analog/45nm/gpdk045/../models/spectre/gpdk045.scs[mc]
  Temperature: 27
  Initial conditions: /net6 = 1.2; /net2 = 0
  Node sets: /net9 = 1.2; /net2 = 1.2; /net11 = 0; /net6 = 0
  Analysis tran: stop=200n errpreset=conservative
  Output v /net6; tran (V) = vtime('tran "/net6")
  Output dft_tran = dft(vtime('tran "/net6") 1.5e-07 1.6e-07 4096 "Hanning" 0 "default" 1.0)
  Output output noise: (PM, DSB, dBc/Hz) = rfOutputNoise("dBc/Hz" ?result "pnoise_pm" ?noiseConvention "DSB") (unticked)
  Output output noise; 1M;(PM, DSB, dBc/Hz) = drplRFValueAt(rfOutputNoise("dBc/Hz" ?result "pnoise_pm" ?noiseConvention "DSB") "1M") (unticked)
Run mode: Single Run, Sweeps and Corners
