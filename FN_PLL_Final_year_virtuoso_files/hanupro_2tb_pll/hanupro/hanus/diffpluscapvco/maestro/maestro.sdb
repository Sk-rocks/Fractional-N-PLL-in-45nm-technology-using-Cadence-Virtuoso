ADE simulation setup
Run mode: Single Run, Sweeps and Corners
Tests:
  hanus_diffpluscapvco_1: hanus/diffpluscapvco/schematic, simulator spectre
