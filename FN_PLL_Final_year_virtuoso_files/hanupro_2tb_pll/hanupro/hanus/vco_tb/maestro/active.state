ADE simulation setup
Test hanus_vco_tb_1: hanus/vco_tb/schematic, simulator spectre
  Models: /home/install/FOUNDRY/analog/45nm/gpdk045/../models/spectre/gpdk045.scs[mc]
  Variables: vc = 473.747m; vdd = 1.2
  Temperature: 27
  Initial conditions: /vout2+ = 1.2; /vout2- = 0; /vout1- = 1.2; /vout1+ = 0
  Analysis pss: engine=Shooting fund=5.12G harms=30 tstab=10n oscana=t p=/vout1+ n=/vout1- errpreset=conservative
  Analysis pnoise: start=1m stop=5M fund=5.12G p=/vout1+ n=/vout1- sweeptype=relative relharmnum=1 noisetype=timeaverage
  Output output noise: (PM, DSB, dBc/Hz) = rfOutputNoise("dBc/Hz" ?result "pnoise_pm" ?noiseConvention "DSB") (unticked)
  Output output noise; 1M;(PM, DSB, dBc/Hz) = drplRFValueAt(rfOutputNoise("dBc/Hz" ?result "pnoise_pm" ?noiseConvention "DSB") "1M")
  Output p(50. /vout4+); pss dBmP = dbm(pvr('pss "/vout4+" 0 50.0)) (unticked)
  Output p(50. /vout4+); pss dBmP; 1 = dbm(harmonic(pvr('pss "/vout4+" 0 50.0) 1)) (unticked)
  Output Phase Noise; dBc/Hz, Relative Harmonic = 1 = pn('pnoise) (unticked)
  Output (CorFreq:PN-3dB) = "6.321e+05:-6.80e+01" (unticked)
  Output frequency(VT("/vout1+")) (unticked)
Run mode: Single Run, Sweeps and Corners
