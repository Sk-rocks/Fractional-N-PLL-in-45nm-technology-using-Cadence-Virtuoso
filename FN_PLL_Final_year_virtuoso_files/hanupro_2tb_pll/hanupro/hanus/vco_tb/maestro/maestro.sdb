ADE simulation setup
Run mode: Single Run, Sweeps and Corners
Tests:
  hanus_vco_tb_1: hanus/vco_tb/schematic, simulator spectre
    Variables: vdd = 1.2; vc = 473.747m
