ADE simulation setup
Run mode: Single Run, Sweeps and Corners
Tests:
  hanus_pll_loop_1: hanus/pll_loop/schematic, simulator spectre
