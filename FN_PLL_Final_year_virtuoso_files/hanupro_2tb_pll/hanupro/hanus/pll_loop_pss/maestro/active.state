ADE simulation setup
Test hanus_pll_loop_1: hanus/pll_loop/schematic, simulator spectre
  Models: /home/install/FOUNDRY/analog/45nm/gpdk045/../models/spectre/gpdk045.scs[tt]
  Temperature: 27
  Initial conditions: /vout2- = 1.2; /vout4+ = 1.2; /vout2+ = 0; /vout4- = 0
  Analysis tran: stop=6u errpreset=moderate maxstep=2n
Run mode: Single Run, Sweeps and Corners
