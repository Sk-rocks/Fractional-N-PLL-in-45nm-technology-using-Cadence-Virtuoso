ADE simulation setup
Test hanus_mash111_test_1: hanus/mash111_test/schematic, simulator spectre
  Models: /home/install/FOUNDRY/analog/45nm/gpdk045/../models/spectre/gpdk045.scs[mc]
  Temperature: 27
  Analysis tran: stop=5u errpreset=conservative
  Output ratio = average((VT("/net1") + (VT("/net3") * 2) + (VT("/net2") * 4)))
  Output average(getData(":pwr" ?result "tran"))
  Signals: /net1 as d0, /net3 as d1, /net2 as d2, /net6 as clk, /net5 as clr
Run mode: Single Run, Sweeps and Corners
