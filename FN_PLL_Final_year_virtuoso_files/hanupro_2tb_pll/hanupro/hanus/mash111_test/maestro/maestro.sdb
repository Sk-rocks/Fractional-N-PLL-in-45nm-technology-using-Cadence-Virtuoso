ADE simulation setup
Run mode: Single Run, Sweeps and Corners
Tests:
  hanus_mash111_test_1: hanus/mash111_test/schematic, simulator spectre
