ADE simulation setup
Run mode: Single Run, Sweeps and Corners
Tests:
  hanus_diffpluscapvcoimprovements_1: hanus/diffpluscapvcoimprovements/schematic, simulator spectre
