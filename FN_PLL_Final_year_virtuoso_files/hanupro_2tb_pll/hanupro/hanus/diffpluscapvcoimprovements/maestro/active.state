ADE simulation setup
Test hanus_diffpluscapvcoimprovements_1: hanus/diffpluscapvcoimprovements/schematic, simulator spectre
  Models: /home/install/FOUNDRY/analog/45nm/gpdk045/../models/spectre/gpdk045.scs[mc]
  Temperature: 27
  Initial conditions: /net66 = 1.2; /net68 = 1.2; /net12 = 0; /net70 = 0
  Analysis tran: stop=200n errpreset=conservative
  Output v /net70; tran (V) = vtime('tran "/net70")
  Output dft(vtime('tran "/net70") 1.5e-07 1.6e-07 4096 "Hanning" 0 "default" 1.0)
  Output output noise: (PM, DSB, dBc/Hz) = rfOutputNoise("dBc/Hz" ?result "pnoise_pm" ?noiseConvention "DSB") (unticked)
  Output output noise; 1M;(PM, DSB, dBc/Hz) = drplRFValueAt(rfOutputNoise("dBc/Hz" ?result "pnoise_pm" ?noiseConvention "DSB") "1M") (unticked)
Run mode: Single Run, Sweeps and Corners
