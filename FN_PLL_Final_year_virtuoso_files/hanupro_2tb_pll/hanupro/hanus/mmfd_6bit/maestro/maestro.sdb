ADE simulation setup
Run mode: Single Run, Sweeps and Corners
Tests:
  hanus_mmfd_6bit_1: hanus/mmfd_6bit/schematic, simulator spectre
    Variables: fc = 10G; vc = {Inclusion List}1.2{Inclusion List}{Inclusion List}0{Inclusion List}; Vdd = 1.2
