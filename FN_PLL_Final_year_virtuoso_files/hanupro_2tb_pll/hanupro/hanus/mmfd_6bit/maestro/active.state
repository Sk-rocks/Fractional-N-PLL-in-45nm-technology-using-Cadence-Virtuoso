ADE simulation setup
Test hanus_mmfd_6bit_1: hanus/mmfd_6bit/schematic, simulator spectre
  Models: /home/install/FOUNDRY/analog/45nm/gpdk045/../models/spectre/gpdk045.scs[mc]
  Variables: fc = 10G; vc = 1.2; Vdd = 1.2
  Temperature: 27
  Analysis tran: stop=200n errpreset=conservative
  Output input frequency = frequency(VT("/net12"))
  Output output frequency = frequency(VT("/net4"))
  Output division ratio = (frequency(VT("/net12")) / frequency(VT("/net4")))
  Output power = average(getData(":pwr" ?result "tran"))
  Signals: /net4 as output, /net12 as input
Run mode: Single Run, Sweeps and Corners
Setup values for test hanus_mmfd_6bit_1: vc = {Inclusion List}1.2{Inclusion List}{Inclusion List}0{Inclusion List}
