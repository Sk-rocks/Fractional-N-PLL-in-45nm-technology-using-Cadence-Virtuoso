ADE simulation setup
Run mode: Single Run, Sweeps and Corners
Tests:
  hanus_vco_tb_1: hanus/vco_tb/schematic, simulator spectre
    Variables: vdd = 1.2; vc = {Inclusion List}0.8{Inclusion List}{From/To}Auto:0:12:1.2{From/To}
