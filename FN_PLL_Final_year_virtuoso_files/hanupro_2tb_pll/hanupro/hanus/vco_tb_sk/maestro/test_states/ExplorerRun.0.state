ADE simulation setup
Test hanus_vco_tb_1: hanus/vco_tb/schematic, simulator spectre
  Models: /home/install/FOUNDRY/analog/45nm/gpdk045/../models/spectre/gpdk045.scs[mc]
  Variables: vc = 0.8; vdd = 1.2
  Temperature: 27
  Initial conditions: /vout4+ = 1.2; /vout4- = 0
  Analysis tran: stop=200n errpreset=conservative
  Output freq = frequency(VT("/vout4-"))
  Output p(50. (/vout4+ /vout4-)); pss dBmP = dbm(pvr('pss "/vout4+" "/vout4-" 50.0))
  Output p(50. (/vout4+ /vout4-)); pss dBmP; 1 = dbm(harmonic(pvr('pss "/vout4+" "/vout4-" 50.0) 1))
  Output harm=1 freq; pss (Hz) = harmonic(xval(getData("vout4+" ?result "pss_fd")) '1)
  Output Phase Noise; dBc/Hz, Relative Harmonic = 1 = pn('pnoise)
  Output (CorFreq:PN-3dB) = "9.147e+04:-6.06e+01"
  Output output noise: (PM, DSB, dBc/Hz) = rfOutputNoise("dBc/Hz" ?result "pnoise_pm" ?noiseConvention "DSB")
  Output output noise; 1M;(PM, DSB, dBc/Hz) = drplRFValueAt(rfOutputNoise("dBc/Hz" ?result "pnoise_pm" ?noiseConvention "DSB") "1M")
  Signals: /vout4-
