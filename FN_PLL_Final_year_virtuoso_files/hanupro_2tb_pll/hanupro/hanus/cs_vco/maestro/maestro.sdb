ADE simulation setup
Run mode: Single Run, Sweeps and Corners
Tests:
  hanus_cs_vco_1: hanus/cs_vco/schematic, simulator spectre
    Variables: vctrl = 1; vdd = 1
