ADE simulation setup
Test hanus_cs_vco_1: hanus/cs_vco/schematic, simulator spectre
  Models: /home/install/FOUNDRY/analog/45nm/gpdk045/../models/spectre/gpdk045.scs[mc]
  Variables: vctrl = 1; vdd = 1
  Temperature: 27
  Initial conditions: /out = 0
  Analysis pss: engine=Shooting fund=9.914G harms=30 tstab=10n oscana=t p=/out n=/gnd! errpreset=conservative
  Analysis pnoise: start=1M stop=2M fund=9.914G p=/out n=/gnd! sweeptype=relative relharmnum=1 noisetype=timeaverage
  Output freq = frequency(VT("/out")) (unticked)
  Output power = average(getData(":pwr" ?result "tran")) (unticked)
  Output p(50. /out) vctrl=1; pss magP = pvr('pss "/out" 0 50.0) (unticked)
  Output p(50. /out) vctrl=1; pss magP; 1 = harmonic(pvr('pss "/out" 0 50.0) 1) (unticked)
  Output harm=1 freq; pss (Hz) = harmonic(xval(getData("out" ?result "pss_fd")) '1) (unticked)
  Output deriv(harmonic(xval(getData("out" ?result "pss_fd")) '1)) (unticked)
  Signals: /out as Vout
Run mode: Single Run, Sweeps and Corners
