ADE simulation setup
Test hanus_pfd_testbench_1: hanus/pfd_testbench/schematic, simulator spectre
  Models: /home/install/FOUNDRY/analog/45nm/gpdk045/../models/spectre/gpdk045.scs[mc]
  Variables: vdd = 2
  Temperature: 27
  Analysis tran: stop=200n errpreset=conservative
  Output Freq = frequency(VT("/q"))
  Signals: /up, /down, /q
Run mode: Single Run, Sweeps and Corners
