ADE simulation setup
Run mode: Single Run, Sweeps and Corners
Tests:
  hanus_pfd_testbench_1: hanus/pfd_testbench/schematic, simulator spectre
    Variables: vdd = 2
