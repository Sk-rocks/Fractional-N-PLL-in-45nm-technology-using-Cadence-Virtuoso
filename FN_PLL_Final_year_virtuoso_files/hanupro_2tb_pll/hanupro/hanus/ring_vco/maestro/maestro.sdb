ADE simulation setup
Run mode: Single Run, Sweeps and Corners
Tests:
  hanus_ring_vco_1: hanus/ring_vco/schematic, simulator spectre
    Variables: vctrl = 1.6
