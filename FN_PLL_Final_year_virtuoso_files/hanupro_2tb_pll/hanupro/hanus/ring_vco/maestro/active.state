ADE simulation setup
Test hanus_ring_vco_1: hanus/ring_vco/schematic, simulator spectre
  Models: /home/install/FOUNDRY/analog/45nm/gpdk045/../models/spectre/gpdk045.scs[mc]
  Variables: vctrl = 1.6
  Temperature: 27
  Initial conditions: /out = 0
  Analysis pnoise: start=1M stop=2M fund=12.23G p=/out n=/gnd! sweeptype=relative relharmnum=1 noisetype=timeaverage
  Analysis pss: engine=Shooting fund=12.23G harms=30 tstab=10n oscana=t p=/out n=/gnd! errpreset=conservative
  Output frequency = frequency(VT("/out"))
  Signals: /out as Vout
Run mode: Single Run, Sweeps and Corners
