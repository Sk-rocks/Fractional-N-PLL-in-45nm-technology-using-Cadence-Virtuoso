ADE simulation setup
Run mode: Single Run, Sweeps and Corners
Tests:
  hanus_vco_new_1: hanus/vco_new/schematic, simulator spectre
    Variables: vdd = 1.2; vc = 0
