ADE simulation setup
Test hanus_vco_new_1: hanus/vco_new/schematic, simulator spectre
  Models: /home/install/FOUNDRY/analog/45nm/gpdk045/../models/spectre/gpdk045.scs[mc]
  Variables: vc = 0; vdd = 1.2
  Temperature: 27
  Initial conditions: /vout5+ = 0; /vout5- = 1.8
  Analysis pss: engine=Shooting fund=15.87G harms=30 tstab=10n oscana=t p=/vout5+ n=/vout5- errpreset=conservative
  Output freq = frequency(VT("/vout5+"))
  Output pwr = average(getData(":pwr" ?result "tran"))
  Output p(50. /vout5+); pss dBmP = dbm(pvr('pss "/vout5+" 0 50.0))
  Output p(50. /vout5+); pss dBmP; 1 = dbm(harmonic(pvr('pss "/vout5+" 0 50.0) 1))
  Output harm=1 freq; pss (Hz) = harmonic(xval(getData("vout5+" ?result "pss_fd")) '1)
  Output output noise: (PM, DSB, dBc/Hz) = rfOutputNoise("dBc/Hz" ?result "pnoise_pm" ?noiseConvention "DSB")
  Output output noise; 10M;(PM, DSB, dBc/Hz) = drplRFValueAt(rfOutputNoise("dBc/Hz" ?result "pnoise_pm" ?noiseConvention "DSB") "10M")
  Output Phase Noise; dBc/Hz, Relative Harmonic = 1 = pn('pnoise)
  Output (CorFreq:PN-3dB) = "2.483e+05:-6.29e+01" (unticked)
  Output output noise; 1M;(PM, DSB, dBc/Hz) = drplRFValueAt(rfOutputNoise("dBc/Hz" ?result "pnoise_pm" ?noiseConvention "DSB") "1M")
  Signals: /vout5+ as out1, /vout5- as out2
Run mode: Single Run, Sweeps and Corners
