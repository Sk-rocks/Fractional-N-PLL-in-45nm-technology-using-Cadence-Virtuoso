ADE simulation setup
Test hanus_new_vco_2_tb_1: hanus/new_vco_2_tb/schematic, simulator spectre
  Models: /home/install/FOUNDRY/analog/45nm/gpdk045/../models/spectre/gpdk045.scs[mc]
  Temperature: 27
  Initial conditions: /vco270 = 0; /vco180 = 0; /vco90 = 0; /vco0 = 0
  Analysis pss: engine=Harmonic Balance fund=6.3G harms=30 tstab=180n oscana=t p=/vco0 errpreset=liberal method=gear2only
  Analysis pnoise: start=1m stop=10M fund=6.3G p=/vco0 sweeptype=relative relharmnum=1 noisetype=timeaverage
  Output output noise: (PM, DSB, dBc/Hz) = rfOutputNoise("dBc/Hz" ?result "pnoise_pm" ?noiseConvention "DSB")
  Output output noise; 1M;(PM, DSB, dBc/Hz) = drplRFValueAt(rfOutputNoise("dBc/Hz" ?result "pnoise_pm" ?noiseConvention "DSB") "1M")
  Output v /vco0; tran (V) = vtime('tran "/vco0") (unticked)
Run mode: Single Run, Sweeps and Corners
