ADE simulation setup
Run mode: Single Run, Sweeps and Corners
Tests:
  hanus_new_vco_2_tb_1: hanus/new_vco_2_tb/schematic, simulator spectre
